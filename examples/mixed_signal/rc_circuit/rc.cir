.title RC
V1 in 0 dc 0 PULSE (0 1 1p 1p 1p 10u 20u)
R in out 13k
C out 0 100p
.end
